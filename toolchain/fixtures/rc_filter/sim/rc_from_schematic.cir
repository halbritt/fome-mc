* Testbench for the SPICE netlist that KiCad exports from rc_filter.kicad_sch
* (`kicad-cli sch export netlist --format spice -o rc_filter.cir`). The smoke
* test writes that export next to a copy of this file and runs it, so the
* simulated R/C values and node names come from the schematic itself.
.include rc_filter.cir
V1 /IN 0 PULSE(0 1 0 1n 1n 1 2)
.tran 1u 6m 0 1u
.meas tran v_at_tau FIND v(/OUT) AT=1m
.meas tran t_half WHEN v(/OUT)=0.5 RISE=1
.end
